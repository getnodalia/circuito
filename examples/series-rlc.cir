Series RLC: f0 = 1/(2 pi sqrt(LC)) = 5.03 kHz, Q = sqrt(L/C)/R = 31.6
V1 in 0 PULSE(0 1 0 1n 1n 1 2) AC 1
R1 in a 10
L1 a b 10m
C1 b 0 100n
.ac dec 40 100 100k
.tran 2u 2m
.end
