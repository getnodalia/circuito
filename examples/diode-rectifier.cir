Half-wave rectifier with a smoothing capacitor
V1 in 0 SIN(0 5 1k)
D1 in out DMOD
C1 out 0 10u
R1 out 0 1k
.model DMOD D(IS=1e-14 N=1 RS=1 CJO=2p)
.tran 20u 5m
.end
